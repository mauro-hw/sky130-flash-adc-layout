* SPDX-License-Identifier: Apache-2.0
* Copyright 2026 Mauro Rodriguez Blasco
*
* First layout exercise: the comparator's NMOS mirror load (XM3, XM4), one unit w=1 l=4 and
* two units each, as one 6-finger device with its guard ring, in the order D B A A B D: B is
* XM4 (the diode, in), A is XM3 (the output, out), D a dummy. The fingers share diffusion, so
* a dummy's outer strip goes to vss and its inner one is shared with B's drain, in: a node of
* low impedance, where a dummy does no harm (next to A it would load out).
* Diffusion strips, left to right: vss in vss out vss in vss. Gates: vss in in in in vss.
* Guard ring (the body): vss. Reference for LVS (scripts/flow.py lvs mirror); Netgen merges
* the fingers in parallel and ignores mult.
.subckt mirror in out vss
XM3 out in vss vss sky130_fd_pr__nfet_01v8_lvt w=1 l=4 mult=2 m=2
XM4 in in vss vss sky130_fd_pr__nfet_01v8_lvt w=1 l=4 mult=2 m=2
XMD in vss vss vss sky130_fd_pr__nfet_01v8_lvt w=1 l=4 mult=2 m=2
.ends mirror
