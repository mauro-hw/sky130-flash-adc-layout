* SPDX-License-Identifier: Apache-2.0
* Copyright 2026 Mauro Rodriguez Blasco
*
* Continuous-time comparator, one of the seven of a 3-bit flash ADC (input range 0 to 0.9 V,
* taps 0.1125 to 0.7875 V): out goes to vdd when inp > inn. A low-Vt PMOS input pair with an
* NMOS mirror load, and an NMOS common-source second stage. About 1 uA of bias from four equal
* high-resistivity poly segments and the diode XM8; the tail carries 2 uA, the second stage 1.
*
* Pre-layout reference for LVS. Every device is a SKY130 device; each transistor is a unit
* repeated m times, with mult= equal to m= so that the PDK's mismatch averages over its
* fingers. Designed in VibeSPICE (project layout-project, block comparator_cmos). The dummies
* at the end are the layout's: switched off, they share diffusion with the node they touch.
.subckt comparator inp inn out vdd vss
* bias: 4 x 314.8 kohm = 1.26 Mohm
XR1 VBIAS R1_R2 vss sky130_fd_pr__res_xhigh_po_0p35 l=55
XR2 R1_R2 R2_R3 vss sky130_fd_pr__res_xhigh_po_0p35 l=55
XR3 R2_R3 R3_R4 vss sky130_fd_pr__res_xhigh_po_0p35 l=55
XR4 R3_R4 vss vss sky130_fd_pr__res_xhigh_po_0p35 l=55
* bias mirror, one unit w=2 l=1: diode 2, tail 4, second-stage load 2
XM8 VBIAS VBIAS vdd vdd sky130_fd_pr__pfet_01v8_lvt w=2 l=1 mult=2 m=2
XM5 TAIL VBIAS vdd vdd sky130_fd_pr__pfet_01v8_lvt w=2 l=1 mult=4 m=4
XM7 out VBIAS vdd vdd sky130_fd_pr__pfet_01v8_lvt w=2 l=1 mult=2 m=2
* input pair, one unit w=2 l=2, 4 + 4 (common centroid)
XM1 OUT1 inp TAIL vdd sky130_fd_pr__pfet_01v8_lvt w=2 l=2 mult=4 m=4
XM2 XM2_drain inn TAIL vdd sky130_fd_pr__pfet_01v8_lvt w=2 l=2 mult=4 m=4
* mirror load and second stage, one unit w=1 l=4
XM3 OUT1 XM2_drain vss vss sky130_fd_pr__nfet_01v8_lvt w=1 l=4 mult=2 m=2
XM4 XM2_drain XM2_drain vss vss sky130_fd_pr__nfet_01v8_lvt w=1 l=4 mult=2 m=2
XM6 out OUT1 vss vss sky130_fd_pr__nfet_01v8_lvt w=1 l=4 mult=2 m=2
* dummies: two on each drain of the pair, two on the mirror's diode node, two on VBIAS
XMDA OUT1 vdd vdd vdd sky130_fd_pr__pfet_01v8_lvt w=2 l=2 mult=2 m=2
XMDB XM2_drain vdd vdd vdd sky130_fd_pr__pfet_01v8_lvt w=2 l=2 mult=2 m=2
XMDC XM2_drain vss vss vss sky130_fd_pr__nfet_01v8_lvt w=1 l=4 mult=2 m=2
XMDD VBIAS vdd vdd vdd sky130_fd_pr__pfet_01v8_lvt w=2 l=1 mult=2 m=2
.ends comparator
